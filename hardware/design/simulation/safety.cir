HSLink-LP Safety gates from actual exported pin-to-net mapping
* Ideal logical gates, no propagation delay or analog startup model.
V0 SYS_RESETn 0 PULSE(0 3.3 1e-05 1n 1n 9.999e-06 2e-05)
V1 SIG_ARM_REQ 0 PULSE(0 3.3 2e-05 1n 1n 1.9999000000000003e-05 4e-05)
V2 POWER_REQ 0 PULSE(0 3.3 4e-05 1n 1n 3.9999e-05 8e-05)
V3 DEBUG_REQ 0 PULSE(0 3.3 8e-05 1n 1n 7.9999e-05 0.00016)
V4 UART_A_REQ 0 PULSE(0 3.3 0.00016 1n 1n 0.00015999900000000002 0.00032)
V5 UART_B_REQ 0 PULSE(0 3.3 0.00032 1n 1n 0.000319999 0.00064)
V6 RESET_REQ 0 PULSE(0 3.3 0.00064 1n 1n 0.000639999 0.00128)
V7 SENSE_REQ 0 PULSE(0 3.3 0.00128 1n 1n 0.0012799990000000002 0.00256)
V8 DISCH_REQ 0 PULSE(0 3.3 0.00256 1n 1n 0.0025599990000000003 0.00512)
* U301.1/2 -> 3
BU301_3 SIG_ARM 0 V=(V(SIG_ARM_REQ)>1.65 && V(SYS_RESETn)>1.65) ? 3.3 : 0
* U301.4/5 -> 6
BU301_6 POWER_SAFE 0 V=(V(POWER_REQ)>1.65 && V(SYS_RESETn)>1.65) ? 3.3 : 0
* U301.9/10 -> 8
BU301_8 DEBUG_ON 0 V=(V(DEBUG_REQ)>1.65 && V(SIG_ARM)>1.65) ? 3.3 : 0
* U301.12/13 -> 11
BU301_11 UART_A_ON 0 V=(V(UART_A_REQ)>1.65 && V(SIG_ARM)>1.65) ? 3.3 : 0
* U302.1/2 -> 3
BU302_3 UART_B_ON 0 V=(V(UART_B_REQ)>1.65 && V(SIG_ARM)>1.65) ? 3.3 : 0
* U302.4/5 -> 6
BU302_6 RESET_ON 0 V=(V(RESET_REQ)>1.65 && V(SIG_ARM)>1.65) ? 3.3 : 0
* U302.9/10 -> 8
BU302_8 SENSE_ON 0 V=(V(SENSE_REQ)>1.65 && V(SIG_ARM)>1.65) ? 3.3 : 0
* U302.12/13 -> 11
BU302_11 DISCH_ARM 0 V=(V(DISCH_REQ)>1.65 && V(SIG_ARM)>1.65) ? 3.3 : 0
* U303.1/2 -> 3
BU303_3 DISCH_ON 0 V=(V(DISCH_ARM)>1.65 && V(POWER_OFF)>1.65) ? 3.3 : 0
* U304.2 -> 4
BU304 POWER_OFF 0 V=V(POWER_SAFE)>1.65 ? 0 : 3.3
.options reltol=1e-5
.save V(SYS_RESETn) V(SIG_ARM_REQ) V(POWER_REQ) V(DEBUG_REQ) V(UART_A_REQ) V(UART_B_REQ) V(RESET_REQ) V(SENSE_REQ) V(DISCH_REQ) V(SIG_ARM) V(POWER_SAFE) V(DEBUG_ON) V(UART_A_ON) V(UART_B_ON) V(RESET_ON) V(SENSE_ON) V(DISCH_ARM) V(DISCH_ON) V(POWER_OFF)
.tran 0.1u 5.12m 0 0.1u
.end
