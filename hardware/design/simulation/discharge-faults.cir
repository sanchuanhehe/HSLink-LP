HSLink-LP discharge abnormal sequence / explicit assumed contact dynamics
* Real pins K601: COM4 DUT_OUT, NO8 SOURCE_POWER, NC6 DISCH_FEED.
* Q902: gate1 DISCH_ON, source2 GND, drain3 DISCH_DRAIN. Body diode GND -> drain.
* Delay/bounce traces are SCENARIOS, not HFD2/005-S guaranteed waveforms.
.param DUT_C=100u EXTERNAL_R=1e12
VSOURCE SOURCE_POWER 0 5.5
VEXT EXTERNAL 0 5.5
REXT EXTERNAL DUT_OUT {EXTERNAL_R}
VPOWER POWER_SAFE 0 PWL(0 3.3 10m 3.3 10.001m 0 100m 0 100.001m 3.3)
VREQ DISCH_REQ 0 PWL(0 0 60m 0 60.001m 3.3)
VARM SIG_ARM 0 PWL(0 3.3 90m 3.3 90.001m 0)
* Ideal stable logic equations match U302/303/304. Gate delays/undervoltage undefined.
BDRV GATE_DRIVE 0 V=(V(DISCH_REQ)>1.65 && V(SIG_ARM)>1.65 && V(POWER_SAFE)<1.65) ? 3.3 : 0
RGATE GATE_DRIVE DISCH_ON 100
R62 DISCH_ON 0 100k
R37 DISCH_ON 0 100k
CGATE DISCH_ON 0 1n
VNO NO_CTL 0 PWL(0 3.3 17m 3.3 17.001m 0 17.2m 0 17.201m 3.3 17.4m 3.3 17.401m 0 107m 0 107.001m 3.3)
VNC NC_CTL 0 PWL(0 0 18m 0 18.001m 3.3 18.2m 3.3 18.201m 0 19m 0 19.001m 3.3 106m 3.3 106.001m 0)
BK601NO SOURCE_POWER DUT_OUT I=V(SOURCE_POWER,DUT_OUT)*(1e-15+V(NO_CTL)/3.3/0.1)
BK601NC DUT_OUT DISCH_FEED I=V(DUT_OUT,DISCH_FEED)*(1e-15+V(NC_CTL)/3.3/0.1)
R57 DISCH_FEED DISCH_DRAIN 1k
BQ902 DISCH_DRAIN 0 I=V(DISCH_DRAIN)*(1e-15+(V(DISCH_ON)>1.5 ? 20 : 0))
DBODY 0 DISCH_DRAIN GENERIC_BODY
CDUT DUT_OUT 0 {DUT_C}
.model GENERIC_BODY D(Is=1e-15 N=1)
.options reltol=1e-5 abstol=1e-12 method=gear
.save V(DUT_OUT) V(DISCH_ON) V(POWER_SAFE) V(NO_CTL) V(NC_CTL) V(DISCH_DRAIN) V(DISCH_FEED) I(VEXT)
.tran 2u 130m 0 2u
.end
